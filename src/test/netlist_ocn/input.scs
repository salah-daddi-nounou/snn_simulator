parameters mem_vth=0.012 spike_duration=0.01 sim_time=0.15 RV_dev=0 \
    gl_Temp_var=0 gl_T=300 gl_RV=0 gl_STO=1
ahdl_include "/home/users/daddinos/projet_cmos28fdsoi_12/snn_simulator/src/wang_model.va"

// =====================================================
subckt cellPMAMTJ T1 T2
parameters param1 param2 param3 param4 param5 param6 param7
    I (T1 T2 ) Model \
	STO      = param1 \
	RV       = param2 \
	T        = param3 \
    Temp_var = param4 \
	PAP      = param5 \
	STO_seed = param6 \
    dev      = param7
ends cellPMAMTJ
// =====================================================

subckt compound_synapse ter2 ter1
parameters seed1 PAP1
	cell1 (ter1 ter2) cellPMAMTJ   param1=gl_STO   param2=gl_RV   param3=gl_T   param4=gl_Temp_var param7=RV_dev   param5=PAP1   param6=seed1
ends compound_synapse

//===================================================
synapse1_1 (input1 output1) compound_synapse PAP1=1 seed1=1289

input_neuron1 (input1 0) vsource type=pulse val0=0 val1=180m width=50m
output_neuron1 (output1 0) vsource type=pulse val0=0 val1=0m width=50m

//input_neuron25 (input25 0) Input_neuron r=0 n_spikes=3.0 spike_duration=spike_duration presenting_time=sim_time
//output_neuron1 (output1) LIF_neuron mem_vth=mem_vth

simulatorOptions options reltol=1e-3 vabstol=1e-6 iabstol=1e-12 temp=27 \
    tnom=27 multithread=on scalem=1.0 scale=1.0 gmin=1e-12 rforce=1 \
    maxnotes=5 maxwarns=5 digits=5 cols=80 pivrel=1e-3
tran tran stop=5u start=0 step=100n maxstep=100n minstep=100n \
    annotate=status oppoint=no maxiters=5
save synapse*.cell*.I:ix all
saveOptions options save=allpub currents=all saveahdlvars=selected
