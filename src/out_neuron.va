// Verilog-A code for leaky integrate-and-fire (LIF) circuit
`include "constants.vams"
`include "disciplines.vams"
//`timescale 100ns / 1ps

// Take care of current blowup error
//nature Current
//  abstol = 1e-14 ;
//  access = I ;
//  units = "A" ;
//  blowup = 1e12 ;
//endnature

// Start of the module
module LIF_verilog_extcap(PostIn) ; //, LICcap);
  inout PostIn;
 // output LICcap;

  electrical PostIn, PostVth, LICcap, LICaux, gnd, LICPostIn;
  branch (PostIn, LICaux) LICswitch;
  branch (LICaux, LICcap) LICcharging;
  branch (LICcap, gnd) LICdischarging, LIC_cap_branch;

  // LIF circuit parameters
  parameter real Rcharging = 100e6 ; // charging resistance // 60
  parameter real Rdischarging =200e6 ; // discharging resistance
  parameter real Rpostdischarge = 10e3 ; // cap discharge during post spike
  parameter real mem_vth = 60e-3;        // neuron membrane potential threshold

  // circuit connecting and disconnecting parameters
  parameter real Ron = 0 ; // connection valid, current flowing
  parameter real Roff = 1e300; // connection invalid, no current flowing

  //variables used
  real state, tfire, t, LICdischarging_R, LICswitch_R, V_fire;
  real membrane;

  // Start of the analog
  analog begin
    membrane = V(LICcap);
    V(gnd) <+ 0;
    V(PostVth) <+ mem_vth;

    // Start of the analysis
    if (analysis("ic")) begin
      state = 0;
      LICdischarging_R = Roff;
      LICswitch_R = Ron;
      //V_fire = 0;

    end else begin
      V(LICPostIn) <+ V(PostIn); // separate circuit and LIF circuit
      V(LICswitch) <+ I(LICswitch) * LICswitch_R; // (dis)connect LIC circuit
      V(LICcharging) <+ I(LICcharging) * Rcharging; // charges the LIF capacitor
      V(LICdischarging) <+ I(LICdischarging) * LICdischarging_R; // discharges the cap
      I(LIC_cap_branch) <+ 300e-12*ddt(V(LIC_cap_branch));    //C =300pF

      // if vcap < vth, post-synaptic neuron is not firing
      if ((V(LICcap) < V(PostVth)) && (state == 0)) begin
        tfire = $abstime;
        LICswitch_R = Ron; // connect LIC circuit

        if (V(PostIn) < V(LICcap)) begin
          LICdischarging_R = Rdischarging; // turn on cap discharging
          LICswitch_R = Roff; // disconnect LIC circuit
        end
      end
      // if vcap > vth, post-synaptic neuron starts firing
      else begin
        LICdischarging_R = Rpostdischarge; // turn on cap discharging
        LICswitch_R = Roff; // disconnect LIC circuit
        state = 1; // set state to 1 for firing
        t = $abstime - tfire; // start timer for pulse width

        // start of the LIF spike
        // Potentiaion part
        if (t <= (0.5e-6)) begin
           V_fire = -100e-3/0.5e-6*t+150e-3;
           V(PostIn) <+ V_fire;
        end
        else if ((t > 0.5e-6 ) && (t <= 6.5e-6)) begin
           V_fire = -100e-3;
           V(PostIn) <+ V_fire;
        end
        else if ((t > 6.5e-6 ) && (t <= 7e-6)) begin
           V_fire = (100e-3/0.5e-6)*(t-7e-6);
           V(PostIn) <+ V_fire;
        end
        // Depression part
        else if ((t > 7e-6 ) && (t <= 7.2e-6)) begin
           V_fire = (100e-3/0.2e-6) * (t-7e-6);
           V(PostIn) <+ V_fire;
        end
        else if ((t > 7.2e-6 ) && (t <= 8.2e-6)) begin
           V_fire = 100e-3;
           V(PostIn) <+ V_fire;
        end
        else if ((t > 8.2e-6 ) && (t <= 8.4e-6)) begin
           V_fire = (100e-3/0.2e-6)*(-t+8.4e-6);
           V(PostIn) <+ V_fire;
        end
        //TODO: refractory period
        else begin
           // Reset the voltage and set other variables
           V_fire = 0;
           V(PostIn) <+ V_fire;
           LICdischarging_R = Roff; // turn off cap discharging
           LICswitch_R = Ron; // turn on LIC switch
           state = 0; // set state to 0 for not firing
        end

      end // post-synaptic neuron ends firing

    end // End of the analysis
   end // End of the analog
endmodule // End of the module
