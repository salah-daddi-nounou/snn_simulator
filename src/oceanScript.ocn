simulator( 'spectre )
design( "${netlist}")
resultsDir( "${process_dir}" )

analysis('tran ?start "0" ?stop "${sim_time}"
        ?step "100n" ?maxstep "100n"  ?minstep "100n" ?write ""  ?writefinal "" ?oppoint "no" ?finalTimeOp nil )

envOption(   'userCmdLineOption "-log ++aps +postlayout" 'restart  "N" 'savestate  "N" 'autoDisplay  nil )
option(	     'multithread "on" 'checklimitdest  "" 'sensfile  "" )
saveOption(  ?infoOptions list(list("modelParameter" "models" "rawfile" "" "" "" nil)   list("element" "inst" "rawfile" "" "" "" nil)
                          list("outputParameter" "output" "rawfile" "" "" "" nil)       list("designParamVals" "parameters" "rawfile" "" "" "" nil)
                          list("primitives" "primitives" "rawfile" "" "" "" nil)        list("subckts" "subckts" "rawfile" "" "" "" nil)
                          list("asserts" "assert" "rawfile" "" "" "" nil)               list("extremeinfo" "all" "logfile" "" "" "" nil) )
                          ?simOutputFormat "" ?saveahdlvars "selected" ?save "none" ?currents "none"  )

;saveOption( 'pwr "devices" )

desVar(	  "gl_STO"       1        	    )
desVar(	  "gl_RV"        2 	            ) ;2
desVar(	  "gl_T"         300	        )
desVar(	  "gl_Temp_var"  0              )

desVar(	  "RV_dev"     ${dev}    )
desVar(	  "sim_time"     ${sim_time}    )
desVar(	  "spike_duration" ${spike_duration}    )
desVar(	  "mem_vth" ${mem_vth}    )

;save('currents "all")
;save('v "all")
;save('all )
save('v "synapse*.cell*.I:ix") ; save the states ix of all the MTJs
save('v "output_neuron*:membrane")

;paramRun()  ;monteRun()   ;run()
run()
selectResults('tran)
outputs()           ; prints all signal names

ocnPrint(?output "${results_file}"
                 ${save_states} v("output_neuron1:membrane") ?step 1m
                 ;v("synapse1_1.cell1.I:ix") v("synapse1_1.cell2.I:ix") v("input1") v("output1")
                 ?numSpaces 1 ?width 1 ?precision 5 ?numberNotation 'none  )

exit()
